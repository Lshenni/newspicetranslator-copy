// Generated by SPICE Translator IR-Based Framework
// Target Format: spectre
// Generated: 2026-01-23 17:32:49
//
// Base models (no corner variations)
inline subckt gpdk090_mimcap (P M)
    parameters area=1 perim=1 geo_fac=1/sqrt(sqrt(area/5u/5u))
    gpdk090_mimcap (P M2)  gpdk090_mimcap_x area=area perim=perim
    Rs (M2 M) resistor r=1
    model gpdk090_mimcap_x capacitor cj=(1-2m*pc_mc*geo_fac)*cap_var*1e-3 cjsw=(1-2m*pc_mc*geo_fac)*1e-10 tc2=-0.008e-6 tc1=-13e-6
ends gpdk090_mimcap

statistics {
    mismatch {
        vary pc_mc dist=gauss std=1/1
    }
}

model gpdk090_mimcap_x capacitor {
    cj = "(1-2m*pc_mc*geo_fac)*cap_var*1e-3"
    cjsw = "(1-2m*pc_mc*geo_fac)*1e-10"
    tc1 = -1.300000e-05
    tc2 = -8.000000e-09
}
