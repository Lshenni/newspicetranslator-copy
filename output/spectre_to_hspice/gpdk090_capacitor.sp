* Generated by SPICE Translator IR-Based Framework
* Target Format: hspice
* Generated: 2026-01-23 16:38:52
*
* Base models (no corner variations)
* Subcircuit: gpdk090_mimcap
.subckt gpdk090_mimcap P M area=1 perim=1

* Geometry scaling
.param geo_fac=1/sqrt(sqrt(area/5e-6/5e-6))
.param mc_en=0
.param cap_var=1
.param mismatch=(1 + mc_en*mc_gauss()*0.002*geo_fac)

.func mc_gauss() {agauss(0,1,1)}

* Capacitance elements (area + sidewall)
Carea P M2 ='cap_var*1e-3*area*mismatch'
Csw P M2 ='cap_var*1e-10*perim*mismatch'

* Series resistance
Rs M2 M 1
.ends gpdk090_mimcap

* Monte Carlo Analysis Instructions (HSPICE)
* ==========================================
*
* The subcircuit above includes Monte Carlo support via:
*   .param mc_en=0    (Monte Carlo enable: 0=off, 1=on)
*   .func mc_gauss()  (Gaussian random number generator)
*
* To run Monte Carlo analysis:
*   1. Enable: .param mc_en=1
*   2. Run: .tran 1n 10n SWEEP MONTE=100
*
* Corner Analysis Instructions
* ==============================
*
* Process corners via cap_var parameter:
*   Typical: .param cap_var=1.0
*   Low:     .param cap_var=0.9
*   High:    .param cap_var=1.1
