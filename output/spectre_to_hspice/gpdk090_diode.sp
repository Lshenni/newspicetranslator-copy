* Generated by SPICE Translator IR-Based Framework
* Target Format: hspice
* Generated: 2026-01-23 15:19:51
*
* Base models (no corner variations)
.model gpdk090_ndio_D diode

.model gpdk090_pdio_D diode

.model gpdk090_nwdio_D diode

.model xdio_hvt diode

.model ydio_hvt diode

.model xdio_na diode

.model gpdk090_ndio_25_D diode

.model gpdk090_pdio_25_D diode

.model xdio_na25 diode
