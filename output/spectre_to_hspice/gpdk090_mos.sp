* Generated by SPICE Translator IR-Based Framework
* Target Format: hspice
* Generated: 2026-01-23 15:19:51
*
* Base models (no corner variations)
.model gpdk090_nmos1v_x nmos

.model gpdk090_pmos1v_x pmos

.model gpdk090_nmos1v_nat_x nmos

.model gpdk090_nmos1v_hvt_x nmos

.model gpdk090_pmos1v_hvt_x pmos

.model gpdk090_nmos2v_x nmos

.model gpdk090_pmos2v_x pmos

.model gpdk090_nmos2v_nat_x nmos
