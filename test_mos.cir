* Numeric validation of MOS model
.include output/ngspice/gpdk090_mos.lib

Vd d 0 0.9
Vg g 0 0
Vs s 0 0
Vb b 0 0

M1 d g s b gpdk090_nmos1v_x L=0.09u W=1u

.dc Vg 0 1.2 0.2
.print dc i(Vd)
.end
