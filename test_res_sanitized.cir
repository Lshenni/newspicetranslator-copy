* Test sanitized resistor
.include output/simready_ngspice/gpdk090_resistor.lib

V1 PLUS 0 1
X1 PLUS 0 0 gpdk090_ressndiff l=0.6e-6 w=0.6e-6

.dc V1 0 1 0.5
.print dc i(V1)
.end
